* Differential reference circuit - Reference Channel Strip (composite)
* ---------------------------------------------------------------------------
* GENERATED by differential/circuits/compose.py from the five block netlists;
* edit the blocks, not this file. Original generic design written for this
* project. Block 1 (PSU) powers blocks 2-5; signal path: triode stage ->
* passive Baxandall tone control -> op-amp make-up gain -> BJT line driver.
* Fixtures: signal generator VIN (600 ohm source) and a 10k external load.
* Run standalone: ngspice -b circuits/channel_strip/channel_strip.cir
* ---------------------------------------------------------------------------
.include ../lib/devices.lib

* ---- Fixtures: signal generator and external load ----
VIN sig_in 0 DC 0 AC 1 SIN(0 0.0424 1k)
RSRC sig_in in_jack 600
RLOAD_EXT out 0 10k

* ---- Block 1 - Power supply (LV regulator + HV B+ chain) ----
VPK_LV pk_lv 0 DC 24.06
VCRES_LV cres_lv 0 DC 2200e-6
BRECT_LV rect_lv 0 V = max(V(pk_lv) - I(VSENS_LV)*(1.5 + 1/(240*V(cres_lv))), 0.6366*V(pk_lv) - I(VSENS_LV)*1.5)
LRECT_LV rect_lv rect_lv_l 10
VSENS_LV rect_lv_l vunreg DC 0
BRIP_LV 0 vunreg I = 2*V(humref)*I(VSENS_LV)
VHUMREF humref 0 DC 0 AC 0
C101 vunreg c101_esr 2200u
RESR_C101 c101_esr 0 0.072
R102 vunreg vz 1k
XD101 0 vz pvz_d101 ZENER_1N4745A
VPVZ_D101 pvz_d101 0 DC 14.6
C102 vz c102_esr 47u
RESR_C102 c102_esr 0 3.95
Q101 vunreg vz vreg Q2N3904
D102 vreg vunreg D1N4148
C103 vreg c103_esr 220u
RESR_C103 c103_esr 0 0.84
R103 vreg 0 2.2k
VPK_HV pk_hv 0 DC 282
VCRES_HV cres_hv 0 DC 47e-6
BRECT_HV rect_hv 0 V = max(V(pk_hv) - I(VSENS_HV)*(150 + 1/(240*V(cres_hv))), 0.6366*V(pk_hv) - I(VSENS_HV)*150)
LRECT_HV rect_hv rect_hv_l 100
VSENS_HV rect_hv_l hv1 DC 0
BRIP_HV 0 hv1 I = 2*V(humref)*I(VSENS_HV)
C104 hv1 c104_esr 47u
RESR_C104 c104_esr 0 5.64
R104 hv1 0 220k
R105 hv1 hv2 10k
C105 hv2 c105_esr 22u
RESR_C105 c105_esr 0 12.06
R106 hv2 bplus 22k
C106 bplus c106_esr 22u
RESR_C106 c106_esr 0 12.06

* ---- Block 2 - Triode gain stage (12AX7 class) ----
C201 in_jack g_in 100n
R201 g_in 0 1Meg
R202 g_in grid 2.2k
XV201 plate grid cath pv_v201 mu_v201 kg_v201 TRIODE_KOREN
VPV_V201 pv_v201 0 DC 1
VMU_V201 mu_v201 0 DC 100
VKG_V201 kg_v201 0 DC 1060
R203 bplus plate 100k
R204 cath 0 1.5k
C202 cath c202_esr 22u
RESR_C202 c202_esr 0 8.44
C203 plate tone_in 220n

* ---- Block 3 - Passive Baxandall tone control ----
R301 tone_in bass_a 47k
RVR301A bass_a bass_t 90k
RVR301B bass_t bass_b 10k
RVR301W bass_t bass_w 1
C301 bass_a bass_w 10n
C302 bass_w bass_b 100n
R302 bass_b 0 4.7k
R303 bass_w tone_out 33k
C303 tone_in treb_a 1n
RVR302A treb_a treb_t 90k
RVR302B treb_t treb_b 10k
RVR302W treb_t tone_out 1
C304 treb_b 0 10n

* ---- Block 4 - Op-amp make-up gain stage ----
C401 tone_out op_in 1u
R401 op_in vref 100k
R402 vreg vref 22k
R403 vref 0 22k
C402 vref c402_esr 47u
RESR_C402 c402_esr 0 3.95
XU401 op_in op_fb op_pin vreg 0 pgbw_u401 pdead_u401 prail_u401 OPAMP_BEH
VPGBW_U401 pgbw_u401 0 DC 3
VPDEAD_U401 pdead_u401 0 DC 0
VPRAIL_U401 prail_u401 0 DC 1
R404 op_pin op_fb 100k
R405 op_fb r405_c 10k
C403 r405_c c403_esr 22u
RESR_C403 c403_esr 0 8.44
R406 op_pin op_out 100
C404 op_out c404_esr 10u
RESR_C404 c404_esr drv_in 13.3
C405 vreg 0 100n
R407 drv_in 0 100k

* ---- Block 5 - Discrete BJT line driver ----
C501 drv_in c501_esr 10u
RESR_C501 c501_esr q1b 13.3
R501 vcc_d q1b 39k
R502 q1b 0 13k
Q501 q1c q1b q1e Q2N3904
R503 q1e q1e2 2.2k
R504 q1e2 0 470
C502 q1e2 c502_esr 100u
RESR_C502 c502_esr 0 1.86
R505 vcc_d q1c 4.7k
Q502 vcc_d q1c q2e Q2N3904
R506 q2e 0 1k
C503 q2e c503_esr 100u
RESR_C503 c503_esr out_c 1.86
R507 out_c out 47
R508 out 0 100k
R509 vreg vcc_d 47
C504 vcc_d c504_esr 220u
RESR_C504 c504_esr 0 0.84

.control
set noaskquit
op
print v(vunreg) v(vreg) v(bplus) v(plate) v(cath) v(vref) v(q1c) v(q2e) v(out)
ac lin 1 1000 1000
print mag(v(out))
.endc
.end
